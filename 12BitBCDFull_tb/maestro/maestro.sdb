ADE simulation setup
Run mode: Single Run, Sweeps and Corners
Tests:
  Inverter1_12BitBCDFull_tb_1: Inverter1/12BitBCDFull_tb/schematic, simulator spectre
