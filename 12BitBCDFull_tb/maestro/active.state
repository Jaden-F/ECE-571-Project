ADE simulation setup
Test Inverter1_12BitBCDFull_tb_1: Inverter1/12BitBCDFull_tb/schematic, simulator spectre
  Models: /top/students/UNGRAD/ECE/jadenf/home/ECE571/TSMC_Cadence/tsmc18rf/rf018.scs[tt]
  Temperature: 27
  Analysis tran: stop=500u errpreset=moderate
  Signals: /CLK, /Q0, /Q1, /Q2, /Q3, /Q4, /Q5, /Q6, /Q7, /SELECT
Run mode: Single Run, Sweeps and Corners
