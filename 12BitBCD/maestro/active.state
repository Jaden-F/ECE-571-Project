ADE simulation setup
Test Inverter1_12BitBCD_1: Inverter1/12BitBCD/schematic, simulator spectre
  Models: /top/students/UNGRAD/ECE/jadenf/home/ECE571/TSMC_Cadence/tsmc18rf/rf018.scs[tt]
  Temperature: 27
  Analysis tran: stop=30u errpreset=moderate
  Signals: /CLK, /D, /Q, /Q', /SELECT
Run mode: Single Run, Sweeps and Corners
