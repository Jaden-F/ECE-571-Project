ADE simulation setup
Run mode: Single Run, Sweeps and Corners
Tests:
  Inverter1_12BitBCD_1: Inverter1/12BitBCD/schematic, simulator spectre
