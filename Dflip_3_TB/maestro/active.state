ADE simulation setup
Test Inverter1_Dflip_3_TB_1: Inverter1/Dflip_3_TB/schematic, simulator spectre
  Models: /top/students/UNGRAD/ECE/jadenf/home/ECE571/TSMC_Cadence/tsmc18rf/rf018.scs[tt]
  Temperature: 27
  Analysis tran: stop=20u  errpreset=moderate
  Signals: /CLK, /D, /Q, /Q', /RESET, /SET
Run mode: Single Run, Sweeps and Corners
