ADE simulation setup
Run mode: Single Run, Sweeps and Corners
Tests:
  Inverter1_Dflip_3_TB_1: Inverter1/Dflip_3_TB/schematic, simulator spectre
